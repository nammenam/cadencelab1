ADE simulation setup
Test lab1_lookup_1: lab1/lookup/schematic, simulator spectre
  Models: /uio/kant/ifi-project00/nanos/design_kit/TSMC65nm_OA/tsmcN65/../models/spectre/toplevel.scs[tt_lib]
  Variables: v1 = 700m
  Temperature: 27
  Analysis dc: (saves the operating point)
  Output id = pv("M0" "id" ?result "dcOpInfo")
  Output gm = pv("M0" "gm" ?result "dcOpInfo")
  Output ft = pv("M0" "ft" ?result "dcOpInfo")
  Output Veff = ((2 * id) / gm)
  Output gmoverid = (gm / id)
Run mode: Single Run, Sweeps and Corners
Setup values for test lab1_lookup_1: v1 = {Inclusion List}200m{Inclusion List}{From/To}Linear:50m:10m:700m{From/To}
