ADE simulation setup
Run mode: Single Run, Sweeps and Corners
Tests:
  lab1_lookup_1: lab1/lookup/schematic, simulator spectre
    Variables: v1 = {Inclusion List}200m{Inclusion List}{From/To}Linear:50m:10m:700m{From/To}
    Outputs: id; gmoverid; Veff; ft; gm
