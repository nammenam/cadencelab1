ADE simulation setup
Test lab1_commonsrc_1: lab1/commonsrc/schematic, simulator spectre
  Models: /uio/kant/ifi-project00/nanos/design_kit/TSMC65nm_OA/tsmcN65/../models/spectre/toplevel.scs[tt_lib]
  Variables: vgs = 700m
  Temperature: 27
  Analysis ac: start=10M stop=10G dec=10
  Analysis dc: (saves the operating point)
  Signals: /net1
Run mode: Single Run, Sweeps and Corners
