ADE simulation setup
Run mode: Single Run, Sweeps and Corners
Tests:
  lab1_commonsrc_1: lab1/commonsrc/schematic, simulator spectre
    Variables: vgs = 700m
