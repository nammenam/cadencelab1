ADE simulation setup
Test lab1_commonsrc_1: lab1/commonsrc/schematic, simulator spectre
  Models: /uio/kant/ifi-project00/nanos/design_kit/TSMC65nm_OA/tsmcN65/../models/spectre/toplevel.scs[tt_lib]
  Variables: k = 1
  Temperature: 27
  Analysis dc: (saves the operating point)
  Analysis ac: start=1M stop=10G dec=10
